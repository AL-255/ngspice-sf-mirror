Native Spectre (.scs) compatibility regression test

.lib 'spectre-compat.scs' mos_tt
.lib 'spectre-compat.scs' passives_tt

* 2-level nested subckt with m=1 vs m=8 (bin 0)
Vd1 d1 0 1.2
Vg1 g1 0 1.2
Xm1 d1 g1 0 0 spe_nmos w=2u l=0.2u m=1

Vd8 d8 0 1.2
Vg8 g8 0 1.2
Xm8 d8 g8 0 0 spe_nmos w=2u l=0.2u m=8

* Bin 1 selection (l=1.0u)
Vd2 d2 0 1.2
Vg2 g2 0 1.2
Xm2 d2 g2 0 0 spe_nmos w=2u l=1.0u m=1

* Vertical BJT with local model sharing subckt name
Vbc c1 0 3.0
Vbe b1 0 0.7
Xq1 c1 b1 0 0 spe_npn

* Diode with compatible=hspice + zero-area breakdown diode (must not NaN)
Vdi di 0 0.65
Dd1 di 0 spe_dio
Vdi0 di0 0 3.3
Dd0 0 di0 spe_dio area=0 pj=0

* Temperature-dependent Spectre resistor (temp -> temper) with m=4
Vr1 r1 0 2.0
Xr1 r1 0 spe_res_t rbase=1000 m=4

* Structural if/else if/else conditional parameters + unparenthesized instance
Vr_c1 rc1 0 2.0
Xr_c1 rc1 0 spe_cond_res mode=1 rval=1000
Vr_c2 rc2 0 2.0
Xr_c2 rc2 0 spe_cond_res mode=2 rval=1000

* Multi-level nested Spectre real functions (spe_r_eff -> spe_scale_step -> spe_is_hi) + signed (-1)**3
Vr_fn rfn 0 3.0
Rr_fn rfn 0 {spe_r_eff(1000, 2.0)}
Vr_nc rnc 0 1.6
Rr_nc rnc 0 {spe_neg_cube}

* Behavioral voltage-dependent Spectre resistor: r = 1000*(1 + 0.25*2.0) = 1500 Ohm -> I = 2/1500
Vr_nl rnl 0 2.0
Xr_nl rnl 0 spe_vdep_res r0=1000 alpha=0.25

* Subcircuit call passing temp expression (temp=27 -> r=1000 -> I = 2mA)
Vr_tw rtw 0 2.0
Xr_tw rtw 0 spe_temp_wrap rbase=1000

* Mutual inductor DC continuity check
Vx1 x1 0 1.0
Rx1 x1 x1m 100
Xxf x1m 0 x2 0 spe_xfmr
Rx2 x2 0 100

.control
op

let fail_count = 0

* 1. Nested 2-level subckt m=8 exact scaling
let ratio_m = i(vd8) / i(vd1)
if abs(ratio_m - 8.0) > 1e-6
    echo "ERROR: nested m=8 ratio = $&ratio_m"
    let fail_count = fail_count + 1
end

* 2. Bin 0 & Bin 1 MOS currents non-zero and distinct
if (i(vd1) > -1e-5) | (i(vd2) > -1e-6) | (abs(i(vd1) - i(vd2)) < 1e-5)
    echo "ERROR: binned BSIM4 currents unexpected"
    let fail_count = fail_count + 1
end

* 3. Vertical BJT collector current
if i(vbc) > -1e-5
    echo "ERROR: BJT collector current unexpected"
    let fail_count = fail_count + 1
end

* 4. Diode forward current + zero-area breakdown diode convergence (finite near-zero current)
if (i(vdi) > -1e-5) | (abs(i(vdi0)) > 1e-9)
    echo "ERROR: Diode current unexpected"
    let fail_count = fail_count + 1
end

* 5. Spectre resistor temp expression + m=4: I = 2.0V / (1000/4) = 8mA
if abs(-i(vr1) - 8e-3) > 1e-9
    echo "ERROR: Spectre resistor current unexpected"
    let fail_count = fail_count + 1
end

* 6. Structural if/else if/else conditional parameters + unparenthesized instance
if (abs(-i(vr_c1) - 1e-3) > 1e-9) | (abs(-i(vr_c2) - 5e-4) > 1e-9)
    echo "ERROR: conditional if/else resistor currents unexpected"
    let fail_count = fail_count + 1
end

* 7. Multi-level nested Spectre real functions: r=1500 -> I=2mA; signed (-1)**3: r=800 -> I=2mA
if (abs(-i(vr_fn) - 2e-3) > 1e-9) | (abs(-i(vr_nc) - 2e-3) > 1e-9)
    echo "ERROR: nested real function or signed power resistor current unexpected"
    let fail_count = fail_count + 1
end

* 8. Behavioral voltage-dependent Spectre resistor: I = 2/1500 = 1.333333e-3
if abs(-i(vr_nl) - (2.0/1500.0)) > 1e-9
    echo "ERROR: behavioral voltage-dependent resistor current unexpected"
    let fail_count = fail_count + 1
end

* 9. Subcircuit call passing temp expression + mutual inductor DC check
if (abs(-i(vr_tw) - 2e-3) > 1e-9) | (abs(-i(vx1) - 1e-2) > 1e-9)
    echo "ERROR: temp subckt arg or mutual_inductor check failed"
    let fail_count = fail_count + 1
end

echo "INFO: $&fail_count of 9 tests failed"
if fail_count > 0
    quit 1
end
quit 0
.endc
.end
