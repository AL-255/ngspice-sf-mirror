// Synthetic Spectre (.scs) PDK regression test library
simulator lang=spectre insensitive=yes
library synth_spe_pdk

section common
parameters vth_shift=0.0
statistics {
    process {
        vary vth_shift dist=gauss std=0.01
    }
}
endsection common

section mos_tt
include "spectre-compat.scs" section=common

inline subckt spe_nmos_inner (d g s b)
parameters l w m=1 trise=0 d_flag=0
parameters leff=(d_flag == 0) ? l : (l + 1e-9)
spe_nmos_inner (d g s b) spe_nmos_mod w=w l=leff trise=trise
ends spe_nmos_inner

subckt spe_nmos (d g s b)
parameters l=0.2u w=1u trise=0
x0 (d g s b) spe_nmos_inner w=w l=l trise=trise
ends spe_nmos

model spe_nmos_mod bsim4 {
  0: type=n version=4.5 lmin=0.1u lmax=0.5u wmin=0.2u wmax=10u tref=25 \
     vth0=0.45+vth_shift u0=0.04 toxm=3e-9 compatible=spectre
  1: type=n version=4.5 lmin=0.5u lmax=10u wmin=0.2u wmax=10u tref=25 \
     vth0=0.50+vth_shift u0=0.045 toxm=3e-9
}
endsection mos_tt

section passives_tt
subckt spe_npn (c b e s)
q0 (c b e s) spe_npn
model spe_npn bjt type=npn struct=vertical is=1e-15 bf=100 tref=25
ends spe_npn

subckt spe_res_t (p n)
parameters rbase=1000 tc=1e-3
r0 (p n) resistor r=rbase*(1 + tc*(temp - 27))
ends spe_res_t

model spe_dio diode type=n is=1e-14 n=1.05 compatible=hspice tref=25
model spe_cap capacitor c=1p coeffs=[0 0]
endsection passives_tt

endlibrary synth_spe_pdk
