// Synthetic Spectre (.scs) PDK regression test library
simulator lang=spectre insensitive=yes
library synth_spe_pdk

section common
parameters vth_shift=0.0
statistics {
    process {
        vary vth_shift dist=gauss std=0.01
    }
}
endsection common

section mos_tt
include "spectre-compat.scs" section=common

inline subckt spe_nmos_inner (d g s b)
parameters l w m=1 trise=0 d_flag=0
parameters leff=(d_flag == 0) ? l : (l + 1e-9)
spe_nmos_inner (d g s b) spe_nmos_mod w=w l=leff trise=trise
ends spe_nmos_inner

subckt spe_nmos (d g s b)
parameters l=0.2u w=1u trise=0
x0 (d g s b) spe_nmos_inner w=w l=l trise=trise
ends spe_nmos

model spe_nmos_mod bsim4 {
  0: type=n version=4.5 lmin=0.1u lmax=0.5u wmin=0.2u wmax=10u tref=25 \
     vth0=0.45+vth_shift u0=0.04 toxm=3e-9 compatible=spectre
  1: type=n version=4.5 lmin=0.5u lmax=10u wmin=0.2u wmax=10u tref=25 \
     vth0=0.50+vth_shift u0=0.045 toxm=3e-9
}
endsection mos_tt

section passives_tt
// Multi-level user-defined Spectre real functions + ternary boundary expansion + signed **
real spe_is_hi(real v) { return (v > 1.5) ? 1 : 0; }
real spe_scale_step(real v) { return (v > 0.5) ? spe_is_hi(v) : 0; }
real spe_r_eff(real rbase, real mode) { return rbase * (1.0 + 0.5 * spe_scale_step(mode)); }
parameters spe_neg_cube = 1000 + ((-1)**3) * 200

subckt spe_npn (c b e s)
q0 (c b e s) spe_npn region=fwd
model spe_npn bjt type=npn struct=vertical is=1e-15 bf=100 tref=25
ends spe_npn

subckt spe_res_t (p n)
parameters rbase=1000 tc=1e-3
r0 (p n) resistor r=rbase*(1 + tc*(temp - 27))
ends spe_res_t

// Structural if / else if / else with conditional parameters + unparenthesized instance
subckt spe_cond_res (p n)
parameters mode=0 rval=1000
parameters reff=rval
if (mode == 1) {
    parameters reff=rval*2
    r_branch p n resistor r=reff
} else if (mode == 2) {
    parameters reff=rval*4
    r_branch p n resistor r=reff
} else {
    r_branch p n resistor r=reff
}
ends spe_cond_res

// Behavioral voltage-dependent resistor + temp in subckt call parameter
subckt spe_vdep_res (p n)
parameters r0=1000 alpha=0.25
r_nl (p n) resistor r=r0*(1 + alpha*v(p,n))
ends spe_vdep_res

subckt spe_temp_wrap (p n)
parameters rbase=1000
x_inner p n spe_cond_res mode=0 rval=rbase*(1 + 0.001*(temp - 27))
ends spe_temp_wrap

// Mutual inductor
subckt spe_xfmr (p1 n1 p2 n2)
l1 (p1 n1) inductor l=1u
l2 (p2 n2) inductor l=1u
k1 mutual_inductor ind1=l1 ind2=l2 coupling=0.5
ends spe_xfmr

model spe_dio diode type=n is=1e-14 n=1.05 compatible=hspice minr=1e-6 imax=10 vjmin=0.1 vb=9.5 tref=25
model spe_cap capacitor c=1p coeffs=[0 0]
endsection passives_tt

endlibrary synth_spe_pdk
